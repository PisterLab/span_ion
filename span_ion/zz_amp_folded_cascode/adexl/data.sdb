ADE simulation setup
Run mode: Single Run, Sweeps and Corners
Tests:
  span_ion:zz_amp_folded_cascode:1: span_ion/zz_amp_folded_cascode/schematic, simulator spectre
Global variables:
  CLOAD = 0
  VDD = 0
  VGN0 = 0
  VGN1 = 0
  VGP0 = 0
  VGP1 = 0
  VGTAIL = 0
  VIN_AC = 1
  VIN_DC = 0

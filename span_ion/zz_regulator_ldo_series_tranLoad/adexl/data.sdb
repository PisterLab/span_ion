ADE simulation setup
Run mode: Single Run, Sweeps and Corners
Tests:
  span_ion:zz_regulator_ldo_series_tranLoad:1: span_ion/zz_regulator_ldo_series_tranLoad/schematic, simulator spectre
Global variables:
  DUTYCYCLE = 0.5
  IHIGH = 3m
  ILOW = 2m
  TD = 1n
  TF = 1
  TPER = 10n
  TSTART = 0
  VDD = 3.3
  VREF = 1.3
  TSTOP = 40n

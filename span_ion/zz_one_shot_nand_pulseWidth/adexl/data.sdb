ADE simulation setup
Run mode: Monte Carlo Sampling
Tests:
  span_ion:zz_one_shot_nand_pulseWidth:1: span_ion/zz_one_shot_nand_pulseWidth/schematic, simulator spectre
Global variables:
  b0 = 0
  b1 = 0
  CAP_VAL = 1e-12
  CL = 0
  TD_POWER = 10n
  VDD = 1.8
  TSTOP = 200u
Corners (nominal off):
  tm_Thi: temperature=125
  tm_Tlo: temperature=-85
Monte Carlo Sampling options: mcmethod=all, mcnumpoints=200

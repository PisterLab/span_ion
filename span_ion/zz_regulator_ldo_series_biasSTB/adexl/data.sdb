ADE simulation setup
Run mode: Single Run, Sweeps and Corners
Tests:
  span_ion:zz_regulator_ldo_series_biasSTB:1: span_ion/zz_regulator_ldo_series_biasSTB/schematic, simulator spectre
Global variables:
  CLOAD = 1p
  RLOAD = 1k
  VDD = 3.3
  VGTAIL = 1
  VREF = 1.2
Corners:
  tm_Thi: temperature=125
  tm_Tlo: temperature=-85

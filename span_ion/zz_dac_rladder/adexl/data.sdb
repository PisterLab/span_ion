ADE simulation setup
Run mode: Monte Carlo Sampling
Tests:
  span_ion:zz_dac_rladder:1: span_ion/zz_dac_rladder/schematic, simulator spectre
Global variables:
  num_bits = 9
  b8 = 1
  b7 = 0
  b6 = 0
  b5 = 0
  b4 = 0
  b3 = 0
  b2 = 0
  b1 = 0
  b0 = 0
  VDD = 3.3
  CL = 0
Monte Carlo Sampling options: mcmethod=all, mcnumpoints=200

ADE simulation setup
Run mode: Monte Carlo Sampling
Tests:
  span_ion:zz_r2r_core:1: span_ion/zz_r2r_core/schematic, simulator spectre
Global variables:
  CL = 0
  VDD = 3.3
  b0 = 0
  b1 = 0
  b2 = 0
  b3 = 0
  b4 = 0
  b5 = 0
  b6 = 0
  b7 = 0
  b8 = 1
  num_bits = 9

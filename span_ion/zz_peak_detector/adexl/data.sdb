ADE simulation setup
Run mode: Single Run, Sweeps and Corners
Tests:
  span_ion:zz_peak_detector:1: span_ion/zz_peak_detector/schematic, simulator spectre
Global variables:
  VDD = 3.3
  VIN_STEP = {From/To}Linear:250m:250m:1.5{From/To}
  Tper = 100n
  tstart = 20n
  tpulse = 20n
  td = 10p
  Cload = 0
  VIN_DC = 0
Corners:
  HiT: temperature=125
  LoT: temperature=-55
  LoLoT: temperature=-85
